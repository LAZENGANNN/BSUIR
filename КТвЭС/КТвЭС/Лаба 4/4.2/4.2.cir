LABA 3.2
V 1 0 PULSE(0 40 0.1u 0.1u 0.1u 10MS 20MS)
R2 2 3 740
R3 4 3 140
L1 1 2 58MH
L2 3 0 58MH
C3 2 4 40.5UF
.TRAN 10MS 20MS
.PROBE
.END
