ZASHITA_4_5
V 1 0 PULSE(0 10 0.1u 0.1u 0.1u 30MS 60MS)
R1 1 2 300
R3 2 3 100
R2 4 0 60
L 3 4 0.18H
C 4 0 1UF
.TRAN 10MS 60MS 0.1u 0.1u
.PROBE
.END
