LABA5A
V1 0 1 95
V2 0 3 33
R1 0 2 140
R2 1 2 740
R3 2 3 1.3K
.dc V1 95 95 95
.print dc i(R1) i(R2) i(R3)
.end
