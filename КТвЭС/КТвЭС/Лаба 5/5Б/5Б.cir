LABA5B
V 1 0 SIN(0 150 50 0)
R1 1 2 0.0001
R 2 0 140
L 2 0 74MH
C 2 0 10.3UF
.TRAN 10MS 20MS
.PROBE
.END
